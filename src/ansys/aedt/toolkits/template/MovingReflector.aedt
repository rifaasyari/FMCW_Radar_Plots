# Ansys Electronics Desktop project, version 2023.2
project datasets:
  $avg_epsilon_r: (10, 13000000) (100, 4500000) (1000, 180000) (10000, 12000) (100000, 4000) (1000000, 150) (10000000, 100) (100000000, 40) (1000000000, 31) (10000000000, 25)
  $avg_conductivity: (10, 0.1) (100, 0.13) (1000, 0.15) (10000, 0.17) (100000, 0.2) (1000000, 0.24) (10000000, 0.3) (100000000, 0.4) (1000000000, 0.8) (10000000000, 8)
materials:
  vacuum: permittivity=1
  human_average_surface: permittivity=54 conductivity=0.03
  pec: conductivity=1e+30
  humanaverage: permittivity=pwl($avg_epsilon_r,Freq) conductivity=pwl($avg_conductivity,Freq)

design moving_reflector (HFSS, SBR+, model units mm)
options: Allow_Material_Override
variables:
  d = 5mm
  t_var = 1s
geometry:
  coordinate_system AntCS = origin=(1000mm, 500mm, 2000mm) x=(1mm, 0mm, 0mm) y=(0mm, 1mm, 0mm)
  RX1_1 = component(RX1, Type="Parametric Beam" Unit=mm Size=0.1mm Sheet=6 MatchedPortImpedance=50ohm Polarization=Horizontal Representation="Far Field" Vertical_BeamWidth=179deg Horizontal_BeamWidth=179deg)
  RX1_Footprint [non-model] = part_of(RX1_1) in AntCS
  RX1_1.rotate(RotateAxis=Y RotateAngle="0.8*pi rad") in AntCS
  RX1_1.duplicate_along_line(XComponent=0mm YComponent=-d/2 ZComponent=0mm NumClones=20) in AntCS
  RX1_2 = component(RX1, Type="Parametric Beam" Unit=mm Size=0.1mm Sheet=6 MatchedPortImpedance=50ohm Polarization=Horizontal Representation="Far Field" Vertical_BeamWidth=179deg Horizontal_BeamWidth=179deg)
  RX1_2.from_dup_along_line(SourceID=154168 WhichClone=0)
  RX1_3 = component(RX1, Type="Parametric Beam" Unit=mm Size=0.1mm Sheet=6 MatchedPortImpedance=50ohm Polarization=Horizontal Representation="Far Field" Vertical_BeamWidth=179deg Horizontal_BeamWidth=179deg)
  RX1_3.from_dup_along_line(SourceID=154168 WhichClone=1)
  RX1_4 = component(RX1, Type="Parametric Beam" Unit=mm Size=0.1mm Sheet=6 MatchedPortImpedance=50ohm Polarization=Horizontal Representation="Far Field" Vertical_BeamWidth=179deg Horizontal_BeamWidth=179deg)
  RX1_4.from_dup_along_line(SourceID=154168 WhichClone=2)
  TX1 = component(RX1, Type="Parametric Beam" Unit=mm Size=0.1mm Sheet=6 MatchedPortImpedance=50ohm Polarization=Horizontal Representation="Far Field" Vertical_BeamWidth=179deg Horizontal_BeamWidth=179deg)
  RX1_Footprint21 [non-model] = part_of(TX1) in AntCS
  TX1.move(TranslateVectorX=0mm TranslateVectorY=d/2 TranslateVectorZ=0mm) in AntCS
  TX1.rotate(RotateAxis=Y RotateAngle="0.8*pi rad") in AntCS
  TX2 = component(RX1, Type="Parametric Beam" Unit=mm Size=0.1mm Sheet=6 MatchedPortImpedance=50ohm Polarization=Horizontal Representation="Far Field" Vertical_BeamWidth=179deg Horizontal_BeamWidth=179deg)
  RX1_Footprint5 [non-model] = part_of(TX2) in AntCS
  TX2.move(TranslateVectorX=0mm TranslateVectorY=d/2+2*d TranslateVectorZ=0mm) in AntCS
  TX2.rotate(RotateAxis=Y RotateAngle="0.8*pi rad") in AntCS
  coordinate_system RelativeCS1 = origin=(-1000mm, -1000mm, 0mm) x=(1mm, 0mm, 0mm) y=(0mm, 1mm, 0mm) in AntCS
  coordinate_system RelativeCS2 = origin=(-1000mm, 1000mm, 0mm) x=(1mm, 0mm, 0mm) y=(0mm, 1mm, 0mm) in AntCS
  Corner_Reflector_10dBsm1 = component(Corner_Reflector_10dBsm, 3D_Component_File_Path=<syslib>/3DComponents/HFSS/ADAS/static_assets/Corner_Reflector_10dBsm.a3dcomp)
  corner_reflector_10dBsm_1 = part_of(Corner_Reflector_10dBsm1) in RelativeCS1
  Corner_Reflector_10dBsm2 = component(Corner_Reflector_10dBsm, 3D_Component_File_Path=<syslib>/3DComponents/HFSS/ADAS/static_assets/Corner_Reflector_10dBsm.a3dcomp)
  corner_reflector_10dBsm2_1 = part_of(Corner_Reflector_10dBsm2) in RelativeCS2
  Corner_Reflector_10dBsm1.rotate(RotateAxis=Z RotateAngle=220deg) in RelativeCS1
  Corner_Reflector_10dBsm2.rotate(RotateAxis=Z RotateAngle=140deg) in RelativeCS2
  Corner_Reflector_10dBsm1.move(TranslateVectorX="-500mm+cos(t_var*pi)*400 mm" TranslateVectorY=0mm TranslateVectorZ=0mm) in RelativeCS1
  Corner_Reflector_10dBsm2.move(TranslateVectorX=-1000mm TranslateVectorY=-500mm TranslateVectorZ=0mm) in RelativeCS2
  coordinate_system RelativeCS3 = origin=(0mm, -1000mm, 0mm) x=(1mm, 0mm, 0mm) y=(0mm, 1mm, 0mm) in RelativeCS2
  Corner_Reflector_10dBsm3 = component(Corner_Reflector_10dBsm, 3D_Component_File_Path=<syslib>/3DComponents/HFSS/ADAS/static_assets/Corner_Reflector_10dBsm.a3dcomp)
  corner_reflector_10dBsm3_1 = part_of(Corner_Reflector_10dBsm3) in RelativeCS3
  Corner_Reflector_10dBsm3.rotate(RotateAxis=Z RotateAngle=180deg) in RelativeCS3
  Corner_Reflector_10dBsm3.move(TranslateVectorX=-1200mm TranslateVectorY=0mm TranslateVectorZ=0mm) in RelativeCS3
boundaries and excitations:
  Corner_Reflector_10dBsm1_SBRRegion1: Hybrid Region Objects=corner_reflector_10dBsm_1 Type=SBR+
  Corner_Reflector_10dBsm1_PerfE1: Perfect E Objects=corner_reflector_10dBsm_1
  Corner_Reflector_10dBsm2_SBRRegion1: Hybrid Region Objects=corner_reflector_10dBsm2_1 Type=SBR+
  Corner_Reflector_10dBsm2_PerfE1: Perfect E Objects=corner_reflector_10dBsm2_1
  Corner_Reflector_10dBsm3_SBRRegion1: Hybrid Region Objects=corner_reflector_10dBsm3_1 Type=SBR+
  Corner_Reflector_10dBsm3_PerfE1: Perfect E Objects=corner_reflector_10dBsm3_1
  RX1: Proxy Port Objects=RX1_Footprint DefinitionPortType=-3 NumModes=1 RenormalizeAllTerminals=false Modes{Mode1{CharImp=Zpi}}
  RX2: Proxy Port Objects=RX1_Footprint2 DefinitionPortType=-3 NumModes=1 RenormalizeAllTerminals=false Modes{Mode1{CharImp=Zpi}}
  RX3: Proxy Port Objects=RX1_Footprint3 DefinitionPortType=-3 NumModes=1 RenormalizeAllTerminals=false Modes{Mode1{CharImp=Zpi}}
  RX4: Proxy Port Objects=RX1_Footprint4 DefinitionPortType=-3 NumModes=1 RenormalizeAllTerminals=false Modes{Mode1{CharImp=Zpi}}
  TX1: Proxy Port Objects=RX1_Footprint21 DefinitionPortType=-3 NumModes=1 RenormalizeAllTerminals=false Modes{Mode1{CharImp=Zpi}}
  TX2: Proxy Port Objects=RX1_Footprint5 DefinitionPortType=-3 NumModes=1 RenormalizeAllTerminals=false Modes{Mode1{CharImp=Zpi}}
mesh:
  initial mesh: UseDynamicMeshing
setups:
  Setup1: HfssDriven IsSbrRangeDoppler SbrRangeDopplerWaveformType=ChirpSeqFmcw ChannelConfiguration=IQChannels IncludeRangeVelocityCouplingEffect SbrRangeDopplerTimeVariable=t_var SbrRangeDopplerCenterFreq=60GHz SbrRangeDopplerA/DSamplingRate=10MHz SbrRangeDopplerRangeResolution=3cm SbrRangeDopplerRangePeriod=3meter SbrRangeDopplerVelocityResolution=1cm_per_sec SbrRangeDopplerVelocityMin=-2m_per_sec SbrRangeDopplerVelocityMax=2m_per_sec DopplerRayDensityPerWavelength=0.2 MaxNumberOfBounces=5 FastFrequencyLooping PTDUTDSimulationSettings=None
source amplitudes:
  RX1:1, RX2:1, RX3:1, RX4:1: 0W 0deg
  TX1:1, TX2:1: 1W 0deg
optimetrics:
  ParametricSetup1: Parametric Sim._Setups=[Setup1]
    sweep t_var: LIN 0s 2s 0.2s
reports:
  Doppler Velocity-Range Plot 1: dB(Response(RX1,TX1)) vs DopplerVelocity, Range on Setup1 : Sweep
  S Parameter Plot 1: re(S(RX1,TX1)), im(S(RX1,TX1)) vs Freq on Setup1 : Sweep [t_var=0s]
